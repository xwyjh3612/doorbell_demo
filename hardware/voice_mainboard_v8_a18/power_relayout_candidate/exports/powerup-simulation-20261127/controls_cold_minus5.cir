controls_cold_minus5
VEXT VIN_PROTECTED 0 5
VCELL BAT_SENSE_IN CELL_NEG 3.7
R_PROTECTION CELL_NEG 0 .02
VESP ESP_3V3 0 3.3
VPAUSE CHG_DISABLE_IO38 0 PWL(0 0 3m 0 3.001m 3.3 6m 3.3 6.001m 0 12m 0)
VADC_ENABLE BAT_ADC_EN9 0 PWL(0 0 3m 0 3.001m 3.3 12m 3.3)
R68 VIN_PROTECTED CHG_CE 10000.0
R69 CHG_DISABLE_IO38 0 100000.0
S_Q7 CHG_CE 0 CHG_DISABLE_IO38 0 NCTRL
.model NCTRL SW(Ron=5 Roff=1e12 Vt=2.5 Vh=0)
R65 VIN_PROTECTED BAT_TEMP 6190.0
R66 BAT_TEMP 0 200000.0
R67 BAT_TEMP CELL_NTC .001
R_PACK_NTC CELL_NTC CELL_NEG 44026.0466916
R64 CHG_PROG 0 12000.0
R73 ESP_3V3 CHG_ACTIVE_N 10000.0
R74 ESP_3V3 CHG_FULL_N 10000.0
V_CHARGER_MON VIN_PROTECTED CHARGER_IN 0
B_TP4056 CHARGER_IN BAT_SENSE_IN I=(V(CHG_CE)>1.2 && V(VIN_PROTECTED)-V(BAT_SENSE_IN)>.15 && ((V(BAT_TEMP)/V(VIN_PROTECTED)>.45 && V(BAT_TEMP)/V(VIN_PROTECTED)<.8) || V(BAT_TEMP)<.01))*min(0.1,max((4.2-V(BAT_SENSE_IN))/.1,0))
R15 BAT_SENSE_IN BAT_GATE 100000.0
R16 BAT_ADC_EN9 0 100000.0
S_Q4 BAT_GATE 0 BAT_ADC_EN9 0 NCTRL
S_Q3 BAT_SENSE_IN BAT_DIV_SW BAT_SENSE_IN BAT_GATE PCTRL
.model PCTRL SW(Ron=10 Roff=1e12 Vt=1.5 Vh=0)
R17 BAT_DIV_SW BAT_ADC2 150000.0
R18 BAT_ADC2 0 100000.0
C28 BAT_ADC2 0 1e-07 IC=0
R_DIV_LEAK BAT_DIV_SW 0 1G
.options method=gear reltol=.003 abstol=1n
.tran 2u 45m 0 2u
.end
