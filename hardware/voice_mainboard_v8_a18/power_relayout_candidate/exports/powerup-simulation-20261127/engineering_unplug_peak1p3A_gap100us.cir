engineering_unplug_peak1p3A_gap100us
V_ADAPTER_REQUEST ADAPTER_REQUEST 0 PWL(0 0 1m 0 1.05m 5 15m 5 15.05m 0 28m 0 28.05m 5 45m 5)
B_ADAPTER_REG 0 ADAPTER_SOURCE I=2*tanh((V(ADAPTER_REQUEST)-V(ADAPTER))/(2*0.05))
Vadapter ADAPTER ADAPTER_SOURCE 0
R_ADAPTER_LEAK ADAPTER 0 1G
R_MAINPATH ADAPTER VIN_PROTECTED 0.129788152
R_CHARGER_RESERVOIR VIN_PROTECTED CHG_IN 0.02
C_CHARGER CHG_IN 0 32u
R70 VIN_PROTECTED UPS_PR1 100000.0
R71 UPS_PR1 0 33200.0
R72 ESP_3V3 SUPPLY_BAT_N47 10000.0
R_MODEM_INPUT SYS_5V MODEM_IN 0.073103451
R_ESP_INPUT SYS_5V ESP_IN 0.113139061
VEXT_EN MUX_EXT_EN 0 PWL(0 0 2.05m 0 3.75m 1 15m 1 15.001m 0 28.05m 0 28.15m 1 45m 1)
VBAT_EN MUX_BAT_EN 0 PWL(0 0 15.101m 0 15.102m 1 28.049m 1 28.05m 0 45m 0)
B_MUX_EXT VIN_PROTECTED SYS_5V I=max(V(VIN_PROTECTED)-V(SYS_5V),0)/.033*V(MUX_EXT_EN)
B_MUX_BAT BAT_BOOST_5V SYS_5V I=max(V(BAT_BOOST_5V)-V(SYS_5V),0)/.033*V(MUX_BAT_EN)
B_MUX_ST SUPPLY_BAT_N47 0 I=(1-V(MUX_EXT_EN))*V(SUPPLY_BAT_N47)/5
R_MUX_LEAK SYS_5V 0 1G
Vbackup BOOST_IDEAL 0 PWL(0 0 6m 0 6.05m 4.992 45m 4.992)
R_BOOST_PATH BOOST_IDEAL BAT_BOOST_5V 0.0864751059
R_C4_PATH SYS_5V C4_CAP 0.09310194874
C4 C4_CAP 0 1.1e-05 IC=0
R_C59_PATH SYS_5V C59_CAP 0.1291309923
C59 C59_CAP 0 1.1e-05 IC=0
R_C61_PATH SYS_5V C61_CAP 0.04420113727
C61 C61_CAP 0 5e-06 IC=0
R_C62_PATH SYS_5V C62_CAP 0.04156588013
C62 C62_CAP 0 5e-08 IC=0
R_C72_PATH SYS_5V C72_CAP 0.0267294745
C72 C72_CAP 0 1.1e-05 IC=0
R_C8_PATH SYS_5V C8_CAP 0.2388324838
C8 C8_CAP 0 0.000376 IC=0
R_C10_PATH MODEM_3V8 C10_CAP 0.02154925367
C10 C10_CAP 0 5e-06 IC=0
R_C11_PATH MODEM_3V8 C11_CAP 0.018427903
C11 C11_CAP 0 5e-08 IC=0
R_C6_PATH MODEM_3V8 C6_CAP 0.02817549994
C6 C6_CAP 0 1.1e-05 IC=0
R_C7_PATH MODEM_3V8 C7_CAP 0.02598971423
C7 C7_CAP 0 1.1e-05 IC=0
R_C74_PATH MODEM_3V8 C74_CAP 0.03619070865
C74 C74_CAP 0 5e-08 IC=0
R_C75_PATH MODEM_3V8 C75_CAP 0.08937265962
C75 C75_CAP 0 0.000176 IC=0
R_C76_PATH MODEM_3V8 C76_CAP 0.09512350697
C76 C76_CAP 0 0.000176 IC=0
R_C13_PATH ESP_3V3 C13_CAP 0.2310154007
C13 C13_CAP 0 5e-08 IC=0
R_C15_PATH ESP_3V3 C15_CAP 0.2517711459
C15 C15_CAP 0 5e-08 IC=0
R_C17_PATH ESP_3V3 C17_CAP 0.269993269
C17 C17_CAP 0 5e-08 IC=0
R_C26_PATH ESP_3V3 C26_CAP 0.0694733314
C26 C26_CAP 0 5e-08 IC=0
R_C57_PATH ESP_3V3 C57_CAP 0.06188570732
C57 C57_CAP 0 1.1e-05 IC=0
R_C58_PATH ESP_3V3 C58_CAP 0.1175449505
C58 C58_CAP 0 5e-08 IC=0
R_C60_PATH ESP_3V3 C60_CAP 0.1154426785
C60 C60_CAP 0 1.1e-05 IC=0
V_MLOAD_CMD MLOAD_CMD 0 PWL(0 .2 9.999m .2 10m 1.3 12m 1.3 12.001m .2 14m .2 14.001m 1.3 17m 1.3 17.001m .2 35m .2 35.001m 1.3 37m 1.3 37.001m .2 45m .2)
V_ELOAD_CMD ELOAD_CMD 0 PWL(0 .15 9.999m .15 10m .35 12m .35 12.001m .15 14m .15 14.001m .35 17m .35 17.001m .15 45m .15)
B_MLOAD MODEM_3V8 0 I=V(MLOAD_CMD)*min(max(V(MODEM_3V8)/1,0),1)
B_ELOAD ESP_3V3 0 I=V(ELOAD_CMD)*min(max(V(ESP_3V3)/1,0),1)
B_AUDIO SYS_5V 0 I=.15*min(max(V(SYS_5V)/2,0),1)
R_R2 MODEM_3V8 BUCK_FB 100000.0
R_R3 BUCK_FB 0 18700.0
B_MODEM_REF MODEM_REF 0 V=.6*min(max((V(MODEM_IN)-2.5)*10,0),1)
R_MODEM_SOFT MODEM_REF MODEM_SOFT 1000
C_MODEM_SOFT MODEM_SOFT 0 1u IC=0
B_MODEM_COMMAND MODEM_COMMAND 0 V=max((V(MODEM_SOFT)+3*(V(MODEM_SOFT)-V(BUCK_FB)))/0.1575400168,0)
R_MODEM_CONTROL MODEM_COMMAND MODEM_CTRL 1
C_MODEM_CONTROL MODEM_CTRL 0 0.0001 IC=0
B_MODEM_DRIVE MODEM_DRV 0 V=min(max(V(MODEM_IN)-.10,0),max(V(MODEM_CTRL),0))
R_MODEM_FET MODEM_DRV MODEM_SW .10
L_MODEM MODEM_SW MODEM_LEND 2.2e-06 IC=0
R_MODEM_DCR MODEM_LEND MODEM_3V8 .039
B_MODEM_INPUT MODEM_IN 0 I=max(-I(B_MODEM_DRIVE)*V(MODEM_DRV),0)/(.85*max(V(MODEM_IN),1))
R_MODEM_LEAK MODEM_3V8 0 100k
R_R59 ESP_3V3 ESP_FB 100000.0
R_R60 ESP_FB 0 22100.0
B_ESP_REF ESP_REF 0 V=.6*min(max((V(ESP_IN)-2.5)*10,0),1)
R_ESP_SOFT ESP_REF ESP_SOFT 1000
C_ESP_SOFT ESP_SOFT 0 1u IC=0
B_ESP_COMMAND ESP_COMMAND 0 V=max((V(ESP_SOFT)+3*(V(ESP_SOFT)-V(ESP_FB)))/0.180999181,0)
R_ESP_CONTROL ESP_COMMAND ESP_CTRL 1
C_ESP_CONTROL ESP_CTRL 0 0.0001 IC=0
B_ESP_DRIVE ESP_DRV 0 V=min(max(V(ESP_IN)-.10,0),max(V(ESP_CTRL),0))
R_ESP_FET ESP_DRV ESP_SW .10
L_ESP ESP_SW ESP_LEND 2.2e-06 IC=0
R_ESP_DCR ESP_LEND ESP_3V3 .039
B_ESP_INPUT ESP_IN 0 I=max(-I(B_ESP_DRIVE)*V(ESP_DRV),0)/(.85*max(V(ESP_IN),1))
R_ESP_LEAK ESP_3V3 0 100k
R_EN ESP_3V3 ESP_EN 10000.0
C56 ESP_EN 0 1e-06 IC=0
R14 ESP_3V3 CALL_BOOT0 10000.0
R19 ADAPTER EXT_DETECT_GATE 10000.0
C29 EXT_DETECT_GATE 0 1e-08 IC=0
R20 EXT_DETECT_GATE 0 100000.0
R21 ESP_3V3 EXT_PRESENT_N_IO10 10000.0
S_Q5 EXT_PRESENT_N_IO10 0 EXT_DETECT_GATE 0 MOS_DETECT
.model MOS_DETECT SW(Ron=5 Roff=1e12 Vt=2.5 Vh=0)
.options method=gear reltol=.003 abstol=1n vntol=1u
.tran 2u 45m 0 2u
.end
