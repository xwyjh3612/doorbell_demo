v5_tps563201_nominal
.include "C:/project/esp32/doorbell_demo_voice/build/ml307-power-reference/tps563201-model/TPS563201_PSPICE_TRANS/TPS563201_TRANS.LIB"
Vups upstream 0 DC 5
Rinput upstream vin .05
Rbulk vin cbulk .08
Cbulk cbulk 0 470u
Rcin vin cin .005
Cin cin 0 12u
Ren vin en 100k
Xbuck en 0 sw bst fb vin TPS563201_TRANS PARAMS: STEADY_STATE=0
Cbst bst sw 100n
L1 sw out 2.2u
Rl out vout .04
Rcout vout cout .002
Cout cout 0 24u
Rtop vout fb 39.2k
Rbottom fb 0 10k
Rboard vout modem .02
Rdec modem dec .003
Cdec dec 0 6u
Rload modem 0 18.9
Istep modem 0 PWL(0 0 3m 0 3.01m 1.8 5m 1.8 5.01m 0 6m 0)
.options reltol=.005 abstol=10n vntol=10u method=trap itl4=200
.tran 100n 6m 0 100n
.end
