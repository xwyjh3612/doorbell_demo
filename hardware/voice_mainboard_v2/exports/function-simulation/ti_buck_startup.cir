TI official model attempt
.include "build/ml307-power-reference/tps563201-model/TPS563201_PSPICE_TRANS/TPS563201_TRANS.LIB"
Ren vin en 100k
Cbst bst sw 100n
Cin vin 0 44u
Rdcr outl out .04
Resr out cap .05
Rfbtop out fb 39.2k
Rfbbottom fb 0 10k
Rload out 0 12.6
Vinput vin 0 PWL(0 0 100u 5)
Xbuck en 0 sw bst fb vin TPS563201_TRANS
Lout sw outl 2.2u
Cout cap 0 494u
.tran 200n 4m 0 100n
.options method=gear reltol=.003
.end
